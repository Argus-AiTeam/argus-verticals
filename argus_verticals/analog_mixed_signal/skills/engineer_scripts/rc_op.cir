Ideal RC operating point
.include models/rc.inc
.temp 27
.op
.save v(in) v(out)
.end
